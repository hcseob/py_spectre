// Design: Playground/spectre_test2
simulator lang=spectre
global 0
parameters R=1e4
include "/cad/tsmc/PDK_GP_2011/tsmcN45/../models/spectre/toplevel.scs" section=top_tt

// Playground/spectre_test_RC/schematic
subckt spectre_test_RC VI VO VSS
parameters _par0=1k C=1p
    R0 (VI VO) resistor r=_par0
    C0 (VO VSS) capacitor c=C
ends spectre_test_RC

// Playground/spectre_test2/schematic
I1 (VO1 VO2 0) spectre_test_RC _par0=1k C=1p
I0 (net2 VO1 0) spectre_test_RC _par0=R C=1e-9/R
V0 (net2 0) vsource dc=1 mag=1 type=dc
simulatorOptions options temp=27
mcSim montecarlo variations=mismatch seed=4321 numruns=3 savefamilyplots=yes savedatainseparatedir=yes {
    ac ac start=100M stop=1G dec=10
}
