// Design: Playground/spectre_test4
simulator lang=spectre
global 0
parameters fsin=100M R=1k
include "/cad/tsmc/PDK_GP_2011/tsmcN45/../models/spectre/toplevel.scs" section=top_tt

// Playground/spectre_test_RC/schematic
subckt spectre_test_RC VI VO VSS
parameters _par0=1k C=1p
    R0 (VI VO) resistor r=_par0
    C0 (VO VSS) capacitor c=C
ends spectre_test_RC

// Playground/spectre_test_RCRC/schematic
subckt spectre_test_RCRC VI VO VSS
parameters R2 C2 R1 C1
    I3 (net7 VO VSS) spectre_test_RC _par0=R2 C=C2
    I0 (VI net7 VSS) spectre_test_RC _par0=R1 C=C1
ends spectre_test_RCRC

// Playground/spectre_test4/schematic
I1 (VO1 VO2 0) spectre_test_RCRC R2=R C2=1.2p R1=7.1k C1=2.1p
I0 (VI VO1 0) spectre_test_RC _par0=1k C=1p
V1 (VI 0) vsource dc=0 mag=1 type=sine ampl=1 freq=fsin
simulatorOptions options temp=27
dcOp dc
dc dc param=R start=100 stop=1k step=100
ac ac start=1 stop=1T dec=10
tran tran stop=100n
noise ( VO2 gnd! ) noise start=1 stop=1T dec=10 annotate=status
xf ( VO2 gnd! ) xf start=1 stop=1T dec=10 annotate=status
pz ( VO2 gnd! ) pz iprobe=V1 freq=1
pss pss fund=100M harms=1 saveinit=yes
