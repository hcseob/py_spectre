// Design: Playground/spectre_test1
simulator lang=spectre
global 0
parameters R=1e3
include "/cad/tsmc/PDK_GP_2011/tsmcN45/../models/spectre/toplevel.scs" section=top_tt

// Playground/spectre_test1/schematic
R0 (net1 VO) resistor r= R scale =1
R1 (VO 0) capacitor c=R / 1e6 scale=1
V0 (net1 0) vsource dc=1 mag=1 type=dc
simulatorOptions options temp=27
ac ac start=1 stop=1G dec=100
dcOp dc
