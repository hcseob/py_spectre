// Design: Playground/spectre_test3
simulator lang=spectre
global 0
include "/cad/tsmc/PDK_GP_2011/tsmcN45/../models/spectre/toplevel.scs" section=top_tt

// Playground/spectre_test_RC/schematic
subckt spectre_test_RC VI VO VSS
parameters R=1k C=1p
    R0 (VI VO) resistor r=R
    C0 (VO VSS) capacitor c=C
ends spectre_test_RC

// Playground/spectre_test_RCRC/schematic
subckt spectre_test_RCRC VI VO VSS
parameters R2 C2 R1 C1
    I3 (net7 VO VSS) spectre_test_RC R=R2 C=C2
    I0 (VI net7 VSS) spectre_test_RC R=R1 C=C1
ends spectre_test_RCRC

// Playground/spectre_test3/schematic
I0 (VI VO1 0) spectre_test_RC R=1k C=1p
I1 (VO1 VO2 0) spectre_test_RCRC
+ R2=2.1k C2=1.2p R1=7.1k C1=2.1p
V0 (VI 0) vsource dc=1 mag=1 type=dc
simulatorOptions options temp=27
    + checklimitdest=psf
ac ac start=1 stop=1G dec=100
