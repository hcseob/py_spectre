// Generated by PySpectre
simulator  lang=spectre
global 0
parameters  VSWEEP=1
R1 0 VO resistor  r=1K
R0 VI VO resistor  r=1K
C0 VO 0 capacitor  c=1p
V0 VI 0 vsource  ampl=1 dc=VSWEEP freq=1G mag=1 type=sine
simulatorOptions options  checklimitdest=psf cols=80 digits=5 gmin=1e-12 iabstol=1e-12 maxnotes=5 maxwarns=5 pivrel=1e-3 reltol=1e-3 rforce=1 scale=1.0 scalem=1.0 sensfile="../psf/sens.output" temp=27 tnom=27 vabstol=1e-6
dcOp dc  annotate=status maxiters=150 maxsteps=10000
dc dc  annotate=status maxiters=150 maxsteps=10000 oppoint=rawfile param=VSWEEP start=0 step=0.1 stop=2
ac ac  annotate=status dec=100 start=1 stop=1T
tran tran  annotate=status maxiters=5 stop=10n
saveOptions options  save=allpub
