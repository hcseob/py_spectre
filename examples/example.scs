// Design: Playground/spectre_4sims
simulator lang=spectre
global 0
parameters VSWEEP=1

// Playground/spectre_4sims/schematic
R1 (0 VO) resistor r=1K
R0 (VI VO) resistor r=1K
C0 (VO 0) capacitor c=1p
V0 (VI 0) vsource dc=VSWEEP mag=1 type=sine ampl=1 freq=1G
simulatorOptions options temp=27
dcOp dc
dc dc param=VSWEEP start=0 stop=2 step=0.1
ac ac start=1 stop=1T dec=100
tran tran stop=10n
