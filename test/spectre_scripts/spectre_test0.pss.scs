// Generated by PySpectre
simulator  lang=spectre
global 0
parameters  R=1k RL=50 fsin=1G
include "/home/rboesch/Python/py_spectre/test/spectre_scripts/ptm_hspice/130nm_bulk.pm"

subckt spectre_test_RC VI VO VSS
parameters  C=1p _par0=1k
R0 VI VO resistor  r=_par0
C0 VO VSS capacitor  c=C
ends spectre_test_RC

subckt spectre_test_RCRC VIM VIP VOM VOP VSS
parameters R1 C1 R2 C2
I5 VIM VOM VSS spectre_test_RC  C=C1 _par0=R1
I4 VIP VOP VSS spectre_test_RC  C=C2 _par0=R2
ends spectre_test_RCRC

subckt ideal_balun d c p n
K0 d 0 p c transformer  n1=2
K1 d 0 c n transformer  n1=2
ends ideal_balun

C1 VAM 0 capacitor  c=1p
C0 VAP 0 capacitor  c=1p
I1 VAM VAP VOM VOP 0 spectre_test_RCRC  C1=1p C2=1p R1=1k R2=1k
I16 VOD VOC VOP VOM ideal_balun
I14 VID 0 VIP VIM ideal_balun
R1 VIM VAM resistor  r=1K
R0 VIP VAP resistor  r=1K
V0 VID 0 vsource  ampl=1 freq=1G mag=1 pacmag=1 type=sine
M0 VG VG 0 0 nmos  l=180.00n w=1u
I10 0 VG isource  dc=100u type=dc
simulatorOptions options  checklimitdest=psf cols=80 digits=5 gmin=1e-12 iabstol=1e-12 maxnotes=5 maxwarns=5 pivrel=1e-3 reltol=1e-3 rforce=1 scale=1.0 scalem=1.0 sensfile="../psf/sens.output" temp=27 tnom=27 vabstol=1e-6
tran tran  annotate=status maxiters=5 stop=100n
finalTimeOP info  what=oppoint where=rawfile
dcOp dc  annotate=status maxiters=150 maxsteps=10000
dcOpInfo info  what=oppoint where=rawfile
dc dc  annotate=status dec=11 maxiters=150 maxsteps=10000 oppoint=rawfile param=RL start=1 stop=100
ac ac  annotate=status dec=92 start=1 stop=1T values=[1k 1e4 1.1e5]
noise VOD gnd! noise  annotate=status freq=1 param=RL start=1 stop=5000 values=[10 1000]
xf VOD gnd! xf  annotate=status start=1 stop=1T
sens VOD for dcOp dc
modelParameter info  what=models where=rawfile
element info  what=inst where=rawfile
outputParameter info  what=output where=rawfile
designParamVals info  what=parameters where=rawfile
saveOptions options  save=allpub
