// Design: Playground/spectre_allsims
simulator lang=spectre
global 0
parameters RL=50 fsin=1G R=1k
include "/home/rboesch/Python/py_spectre/test/spectre_scripts/ptm_hspice/130nm_bulk.pm"

// Playground/spectre_test_RC/schematic
subckt spectre_test_RC VI VO VSS
parameters _par0=1k C=1p
    R0 (VI VO) resistor r=_par0
    C0 (VO VSS) capacitor c=1*(C)
ends spectre_test_RC

// Playground/spectre_test_RCRC/schematic
subckt spectre_test_RCRC VIM VIP VOM VOP VSS
parameters R1 C1 R2 C2
    I5 (VIM VOM VSS) spectre_test_RC _par0=R1 C=C1
    I4 (VIP VOP VSS) spectre_test_RC _par0=R2 C=C2
ends spectre_test_RCRC

// analogLib/ideal_balun/schematic
subckt ideal_balun d c p n
    K0 (d 0 p c) transformer n1=2
    K1 (d 0 c n) transformer n1=2
ends ideal_balun

// Playground/spectre_allsims/schematic
C1 (VAM 0) capacitor c=1p
C0 (VAP 0) capacitor c=1p
I1 (VAM VAP VOM VOP 0) spectre_test_RCRC R1=1k C1=1p R2=1k C2=1p
I16 (VOD VOC VOP VOM) ideal_balun
I14 (VID 0 VIP VIM) ideal_balun
R1 (VIM VAM) resistor r=1K
R0 (VIP VAP) resistor r=1K
V0 (VID 0) vsource mag=1 type=sine pacmag=1 ampl=1 freq=1G
M0 (VG VG 0 0) nmos w=1u l=180.00n
I10 (0 VG) isource dc=100u type=dc
simulatorOptions options temp=27
tran tran stop=100n
dcOp dc
dc dc param=RL start=1 stop=100 dec=11
ac ac start=1 stop=1T dec=92 values=[1k 1e4 1.1e5]
noise ( VOD gnd! ) noise freq=1 param=RL start=1 stop=5000 values=[10 1000] annotate=status
xf ( VOD gnd! ) xf start=1 stop=1T annotate=status
sens (VOD ) for (dcOp dc )
