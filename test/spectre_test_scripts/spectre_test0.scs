// Design: Playground/spectre_allsims
simulator lang=spectre
global 0
parameters RL=50 fsin=1G R=1k
include "/home/rboesch/Python/py_spectre_tests/py_spectre/examples/HSpiceModels/130nm_bulk.pm"

// Playground/spectre_test_RC/schematic
subckt spectre_test_RC VI VO VSS
parameters _par0=1k C=1p
    R0 (VI VO) resistor r=_par0
    C0 (VO VSS) capacitor c=C
ends spectre_test_RC

// Playground/spectre_test_RCRC/schematic
subckt spectre_test_RCRC VI VO VSS
parameters R2 C2 R1 C1
    I3 (net7 VO VSS) spectre_test_RC _par0=R2 C=C2
    I0 (VI net7 VSS) spectre_test_RC _par0=R1 C=C1
ends spectre_test_RCRC

// Playground/spectre_allsims/schematic
I1 (VO1 VO2 0) spectre_test_RCRC R2=2*(R/2)+0 C2=1.2p R1=7.1k C1=2.1p
I0 (VI VO1 0) spectre_test_RC _par0=1k C=1p
R0 (VNOISE 0) resistor r=RL isnoisy=yes
V0 (VI 0) vsource mag=1 type=sine pacmag=1 ampl=1 freq=1G
PORT1 (VNOISE 0) port r=50 num=1 dc=1 type=sine freq=1G ampl=1 sinedc=0
M0 (VG VG 0 0) nmos w=1u l=180.00n
I10 (0 VG) isource dc=100u type=dc
simulatorOptions options temp=27
tran tran stop=100n
dcOp dc
dc dc param=RL start=1 stop=100 dec=11
ac ac start=1 stop=1T dec=92 values=[1k 1e4 1.1e5]
noise ( VNOISE gnd! ) noise freq=1 param=RL start=1 stop=5000 values=[10 1000] iprobe=PORT1 annotate=status
xf ( VO2 gnd! ) xf start=1 stop=1T annotate=status
sens (VNOISE VO2) to (R0 I0.R0) for (dcOp dc )
