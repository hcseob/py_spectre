// Generated by PySpectre
simulator  lang=spectre
global 0
parameters  VGBIAS=1
include "/cad/tsmc/PDK_GP_2011/tsmcN45/../models/spectre/toplevel.scs" section=top_tt
include "/home/rboesch/cad-tsmc40/Sandbox/saveop.scs"
M0 VG VG 0 0 nch ps=500n pd=500n ad=1.54e-14 m=1 l=40n nf=1 nrd=0.172100 as=1.54e-14 w=140n nrs=0.172100 sb=110n sa=110n sd=140n
V0 VG 0 vsource type=dc dc=VGBIAS
simulatorOptions options reltol=1e-3 maxnotes=5 tnom=27 scale=1.0 temp=27 gmin=1e-12 sensfile="../psf/sens.output" digits=5 cols=80 vabstol=1e-6 pivrel=1e-3 maxwarns=5 rforce=1 scalem=1.0 checklimitdest=psf iabstol=1e-12
dcOp dc write="spectre.dc" annotate=status maxiters=150 maxsteps=10000
dcOpInfo info what=oppoint where=rawfile
dc dc oppoint=rawfile maxiters=150 stop=1 param=VGBIAS annotate=status start=0 step=0.01 maxsteps=10000
modelParameter info what=models where=rawfile
element info what=inst where=rawfile
outputParameter info what=output where=rawfile
designParamVals info what=parameters where=rawfile
primitives info what=primitives where=rawfile
save V0:p
saveOptions options save=allpub
