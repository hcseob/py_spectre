// Generated by PySpectre
simulator  lang=spectre
global 0
parameters  RL=50 R=1k fsin=1G
include "/home/rboesch/Python/py_spectre_tests/py_spectre/examples/HSpiceModels/130nm_bulk.pm"

subckt spectre_test_RC VI VO VSS
parameters  C=1p _par0=1k
R0 VI VO resistor r=_par0
C0 VO VSS capacitor c=C
ends spectre_test_RC

subckt spectre_test_RCRC VI VO VSS
parameters R2 C2 R1 C1
I3 net7 VO VSS spectre_test_RC C=C2 _par0=R2
I0 VI net7 VSS spectre_test_RC C=C1 _par0=R1
ends spectre_test_RCRC

I1 VO1 VO2 0 spectre_test_RCRC C2=1.2p C1=2.1p R1=7.1k R2=2*R/2+0
I0 VI VO1 0 spectre_test_RC C=1p _par0=1k
R0 VNOISE 0 resistor r=RL isnoisy=yes
V0 VI 0 vsource freq=1G pacmag=1 type=sine ampl=1 mag=1
PORT1 VNOISE 0 port num=1 ampl=1 dc=1 sinedc=0 r=50 freq=1G type=sine
M0 VG VG 0 0 nmos l=180.00n w=1u
I10 0 VG isource type=dc dc=100u
simulatorOptions options reltol=1e-3 maxnotes=5 tnom=27 scale=1.0 temp=27 gmin=1e-12 sensfile="../psf/sens.output" digits=5 cols=80 vabstol=1e-6 pivrel=1e-3 maxwarns=5 rforce=1 scalem=1.0 checklimitdest=psf iabstol=1e-12
tran tran write="./psf/test0/spectre.ic" annotate=status maxiters=5 stop=100n writefinal="./psf/test0/spectre.fc"
finalTimeOP info what=oppoint where=rawfile
dcOp dc write="./psf/test0/spectre.dc" annotate=status maxiters=150 maxsteps=10000
dcOpInfo info what=oppoint where=rawfile
dc dc oppoint=rawfile maxiters=150 stop=100 param=RL annotate=status start=1 maxsteps=10000 dec=11
ac ac values=[1k 1e4 1.1e5] start=1 dec=92 stop=1T annotate=status
noise VNOISE gnd! noise iprobe=PORT1 stop=5000 param=RL annotate=status start=1 values=[10 1000] freq=1
xf VO2 gnd! xf annotate=status start=1 stop=1T
sens VNOISE VO2 to R0 I0.R0 for dcOp dc
modelParameter info what=models where=rawfile
element info what=inst where=rawfile
outputParameter info what=output where=rawfile
designParamVals info what=parameters where=rawfile
primitives info what=primitives where=rawfile
saveOptions options save=allpub
