// Generated for: spectre
// Generated on: Apr 30 15:52:56 2015
// Design library name: Playground
// Design cell name: spectre_test5
// Design view name: schematic
simulator lang=spectre
global 0
parameters VGBIAS=1
include "/cad/tsmc/PDK_GP_2011/tsmcN45/../models/spectre/toplevel.scs" section=top_tt
include "/home/rboesch/cad-tsmc40/Sandbox/saveop.scs"

// Library name: Playground
// Cell name: spectre_test5
// View name: schematic
M0 (VG VG 0 0) nch l=40n w=140n m=1 nf=1 sd=140n ad=1.54e-14 as=1.54e-14 \
        pd=500n ps=500n nrd=0.172100 nrs=0.172100 sa=110n sb=110n
V0 (VG 0) vsource dc=VGBIAS type=dc
simulatorOptions options reltol=1e-3 vabstol=1e-6 iabstol=1e-12 temp=27 \
    tnom=27 scalem=1.0 scale=1.0 gmin=1e-12 rforce=1 maxnotes=5 maxwarns=5 \
    digits=5 cols=80 pivrel=1e-3 sensfile="../psf/sens.output" \
    checklimitdest=psf
dcOp dc write="spectre.dc" maxiters=150 maxsteps=10000 annotate=status
dcOpInfo info what=oppoint where=rawfile
dc dc param=VGBIAS start=0 stop=1 step=0.01 oppoint=rawfile maxiters=150 \
    maxsteps=10000 annotate=status
modelParameter info what=models where=rawfile
element info what=inst where=rawfile
outputParameter info what=output where=rawfile
designParamVals info what=parameters where=rawfile
primitives info what=primitives where=rawfile
save V0:p
saveOptions options save=allpub
